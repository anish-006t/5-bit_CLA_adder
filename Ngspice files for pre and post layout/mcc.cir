*manchester carry chain circuit
.include TSMC_180nm.txt
.include gates.cir
.param SUPPLY=1.8
.param LAMBDA=0.09u
.global gnd vdd

.param width_N=20*LAMBDA
.param width_P=width_N

VCK ck 0 PULSE(0 {SUPPLY} 5n 10p 10p 10n 20n)

Va0 a0_l 0 DC 1.8
Va1 a1_l 0 DC 0
Va2 a2_l 0 DC 1.8
Va3 a3_l 0 DC 0
Va4 a4_l 0 DC 1.8

Vb0 b0_l 0 DC 0
Vb1 b1_l 0 DC 1.8
Vb2 b2_l 0 DC 0
Vb3 b3_l 0 DC 1.8
Vb4 b4_l 0 DC 0

Vcin cin 0 DC 1.8

X_P0 p0 a0_l b0_l vdd gnd xor2
X_G0 g0 a0_l b0_l vdd gnd and2

X_P1 p1 a1_l b1_l vdd gnd xor2
X_G1 g1 a1_l b1_l vdd gnd and2

X_P2 p2 a2_l b2_l vdd gnd xor2
X_G2 g2 a2_l b2_l vdd gnd and2

X_P3 p3 a3_l b3_l vdd gnd xor2
X_G3 g3 a3_l b3_l vdd gnd and2

X_P4 p4 a4_l b4_l vdd gnd xor2
X_G4 g4 a4_l b4_l vdd gnd and2

* stage -1: C0_bar at N0

Mpre0 N0 ck vdd vdd CMOSP W={width_P}   L={2*LAMBDA}
+ AS={5*width_P*LAMBDA} PS={10*LAMBDA+2*width_P} AD={5*width_P*LAMBDA} PD={10*LAMBDA+2*width_P}
M_c0 N1 cin nbot0 0 CMOSN W={width_N}   L={2*LAMBDA}
+ AS={5*width_N*LAMBDA} PS={10*LAMBDA+2*width_N} AD={5*width_N*LAMBDA} PD={10*LAMBDA+2*width_N}
M_bot0 nbot0 ck 0 0 CMOSN W={width_N}   L={2*LAMBDA}
+ AS={5*width_N*LAMBDA} PS={10*LAMBDA+2*width_N} AD={5*width_N*LAMBDA} PD={10*LAMBDA+2*width_N}
C_N0 N0 0 8f

* ---- Stage 0: C1_bar at N1 ----
Mpre1 N1 ck vdd vdd CMOSP W={width_P}   L={2*LAMBDA}
+ AS={5*width_P*LAMBDA} PS={10*LAMBDA+2*width_P} AD={5*width_P*LAMBDA} PD={10*LAMBDA+2*width_P}
M_g0 N1 g0 nbot1 0 CMOSN W={width_N}   L={2*LAMBDA}
+ AS={5*width_N*LAMBDA} PS={10*LAMBDA+2*width_N} AD={5*width_N*LAMBDA} PD={10*LAMBDA+2*width_N}
M_p0 N0 p0 N1 0 CMOSN W={width_N}   L={2*LAMBDA}
+ AS={5*width_N*LAMBDA} PS={10*LAMBDA+2*width_N} AD={5*width_N*LAMBDA} PD={10*LAMBDA+2*width_N}
M_bot1 nbot1 ck 0 0 CMOSN W={width_N}   L={2*LAMBDA}
+ AS={5*width_N*LAMBDA} PS={10*LAMBDA+2*width_N} AD={5*width_N*LAMBDA} PD={10*LAMBDA+2*width_N}
C_N1 N1 0 8f

Xinvc1 C1 N1 vdd gnd inv

* ---- Stage 1: C2_bar at N2 ----
Mpre2 N2 ck vdd vdd CMOSP W={width_P}   L={2*LAMBDA}
+ AS={5*width_P*LAMBDA} PS={10*LAMBDA+2*width_P} AD={5*width_P*LAMBDA} PD={10*LAMBDA+2*width_P}
M_g1 N2 g1 nbot2 0 CMOSN W={width_N}   L={2*LAMBDA}
+ AS={5*width_N*LAMBDA} PS={10*LAMBDA+2*width_N} AD={5*width_N*LAMBDA} PD={10*LAMBDA+2*width_N}
M_p1 N1 p1 N2 0 CMOSN W={width_N}   L={2*LAMBDA}
+ AS={5*width_N*LAMBDA} PS={10*LAMBDA+2*width_N} AD={5*width_N*LAMBDA} PD={10*LAMBDA+2*width_N}
M_bot2 nbot2 ck 0 0 CMOSN W={width_N}   L={2*LAMBDA}
+ AS={5*width_N*LAMBDA} PS={10*LAMBDA+2*width_N} AD={5*width_N*LAMBDA} PD={10*LAMBDA+2*width_N}
C_N2 N2 0 8f

Xinvc2 C2 N2 vdd gnd inv

* ---- Stage 2: C3_bar at N3 ----
Mpre3 N3 ck vdd vdd CMOSP W={width_P}   L={2*LAMBDA}
+ AS={5*width_P*LAMBDA} PS={10*LAMBDA+2*width_P} AD={5*width_P*LAMBDA} PD={10*LAMBDA+2*width_P}
M_g2 N3 g2 nbot3 0 CMOSN W={width_N}   L={2*LAMBDA}
+ AS={5*width_N*LAMBDA} PS={10*LAMBDA+2*width_N} AD={5*width_N*LAMBDA} PD={10*LAMBDA+2*width_N}
M_p2 N2 p2 N3 0 CMOSN W={width_N}   L={2*LAMBDA}
+ AS={5*width_N*LAMBDA} PS={10*LAMBDA+2*width_N} AD={5*width_N*LAMBDA} PD={10*LAMBDA+2*width_N}
M_bot3 nbot3 ck 0 0 CMOSN W={width_N}   L={2*LAMBDA}
+ AS={5*width_N*LAMBDA} PS={10*LAMBDA+2*width_N} AD={5*width_N*LAMBDA} PD={10*LAMBDA+2*width_N}
C_N3 N3 0 8f

Xinvc3 C3 N3 vdd gnd inv

* ---- Stage 3: C4_bar at N4 ----
Mpre4 N4 ck vdd vdd CMOSP W={width_P}   L={2*LAMBDA}
+ AS={5*width_P*LAMBDA} PS={10*LAMBDA+2*width_P} AD={5*width_P*LAMBDA} PD={10*LAMBDA+2*width_P}
M_g3 N4 g3 nbot4 0 CMOSN W={width_N}   L={2*LAMBDA}
+ AS={5*width_N*LAMBDA} PS={10*LAMBDA+2*width_N} AD={5*width_N*LAMBDA} PD={10*LAMBDA+2*width_N}
M_p3 N3 p3 N4 0 CMOSN W={width_N}   L={2*LAMBDA}
+ AS={5*width_N*LAMBDA} PS={10*LAMBDA+2*width_N} AD={5*width_N*LAMBDA} PD={10*LAMBDA+2*width_N}
M_bot4 nbot4 ck 0 0 CMOSN W={width_N}   L={2*LAMBDA}
+ AS={5*width_N*LAMBDA} PS={10*LAMBDA+2*width_N} AD={5*width_N*LAMBDA} PD={10*LAMBDA+2*width_N}
C_N4 N4 0 8f

Xinvc4 C4 N4 vdd gnd inv

* ---- Stage 4: C5_bar at N5 (final carry) ----
Mpre5 N5 ck vdd vdd CMOSP W={width_P}   L={2*LAMBDA}
+ AS={5*width_P*LAMBDA} PS={10*LAMBDA+2*width_P} AD={5*width_P*LAMBDA} PD={10*LAMBDA+2*width_P}
M_g4 N5 g4 nbot5 0 CMOSN W={width_N}   L={2*LAMBDA}
+ AS={5*width_N*LAMBDA} PS={10*LAMBDA+2*width_N} AD={5*width_N*LAMBDA} PD={10*LAMBDA+2*width_N}
M_p4 N4 p4 N5 0 CMOSN W={width_N}   L={2*LAMBDA}
+ AS={5*width_N*LAMBDA} PS={10*LAMBDA+2*width_N} AD={5*width_N*LAMBDA} PD={10*LAMBDA+2*width_N}
M_bot5 nbot5 ck 0 0 CMOSN W={width_N}   L={2*LAMBDA}
+ AS={5*width_N*LAMBDA} PS={10*LAMBDA+2*width_N} AD={5*width_N*LAMBDA} PD={10*LAMBDA+2*width_N}
C_N5 N5 0 10f

Xinvc5 C5 N5 vdd gnd inv

.tran 0.1n 100n

.control

set hcopypscolor = 1 *White background for saving plots
set color0=white
set color1=black

run
set curplottitle = "manchester_carry_chain"

plot V(C1)+8 V(C2)+6 V(C3)+4 V(C4)+2 V(C5) V(ck)+10
meas tran t_eval TRIG V(ck) VAL=0.5*{SUPPLY} RISE=2 TARG V(c5) VAL=0.9*{SUPPLY} RISE=2

echo "t_eval = " $&t_eval

.endc
.end
