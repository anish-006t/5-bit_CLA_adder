* SPICE3 file created from CLA_5.ext - technology: scmos

.option scale=0.09u

.include TSMC_180nm.txt

.param SUPPLY=1.8

.global gnd vdd
Vdd vdd 0 {SUPPLY}

VCK ck_mcc 0 PULSE(0 {SUPPLY} 5n 10p 10p 10n 20n)

Va0 a0_l 0 DC 1.8
Va1 a1_l 0 DC 0
Va2 a2_l 0 DC 1.8
Va3 a3_l 0 DC 0
Va4 a4_l 0 DC 1.8

Vb0 b0_l 0 DC 0
Vb1 b1_l 0 DC 1.8
Vb2 b2_l 0 DC 0
Vb3 b3_l 0 DC 1.8
Vb4 b4_l 0 DC 0

Vcin c0_l 0 DC 1.8

M1000 vdd a1_l a_58_173# w_45_202# CMOSP w=20 l=2
+  ad=4860 pd=1766 as=200 ps=100
M1001 a_175_175# b2_l vdd w_162_204# CMOSP w=20 l=2
+  ad=200 pd=100 as=0 ps=0
M1002 vdd a4_l a_405_180# w_392_209# CMOSP w=20 l=2
+  ad=0 pd=0 as=200 ps=100
M1003 p1 b1_l a1_l w_49_95# CMOSP w=20 l=2
+  ad=200 pd=100 as=100 ps=50
M1004 p1 a_32_69# b1_l Gnd CMOSN w=10 l=2
+  ad=100 pd=60 as=50 ps=30
M1005 C3 a_161_n29# gnd Gnd CMOSN w=10 l=2
+  ad=90 pd=38 as=3270 ps=1196
M1006 a_51_173# a1_l gnd Gnd CMOSN w=20 l=2
+  ad=200 pd=100 as=0 ps=0
M1007 g2 a_175_175# gnd Gnd CMOSN w=10 l=2
+  ad=50 pd=30 as=0 ps=0
M1008 a_398_180# a4_l gnd Gnd CMOSN w=20 l=2
+  ad=200 pd=100 as=0 ps=0
M1009 a_149_71# a2_l vdd w_136_90# CMOSP w=20 l=2
+  ad=100 pd=50 as=0 ps=0
M1010 a_367_n29# Ck_mcc vdd w_404_n1# CMOSP w=20 l=2
+  ad=280 pd=68 as=0 ps=0
M1011 g2 a_175_175# vdd w_162_204# CMOSP w=20 l=2
+  ad=100 pd=50 as=0 ps=0
M1012 p4 a_379_76# b4_l Gnd CMOSN w=10 l=2
+  ad=100 pd=60 as=50 ps=30
M1013 C5 a_367_n29# vdd w_475_n7# CMOSP w=20 l=2
+  ad=280 pd=68 as=0 ps=0
M1014 g0 a_n68_172# gnd Gnd CMOSN w=10 l=2
+  ad=50 pd=30 as=0 ps=0
M1015 C0 a_n86_n52# vdd w_n43_n164# CMOSP w=20 l=2
+  ad=180 pd=58 as=0 ps=0
M1016 C2 a_56_n29# gnd Gnd CMOSN w=10 l=2
+  ad=90 pd=38 as=0 ps=0
M1017 g4 a_405_180# vdd w_392_209# CMOSP w=20 l=2
+  ad=100 pd=50 as=0 ps=0
M1018 a_267_76# a3_l gnd Gnd CMOSN w=10 l=2
+  ad=100 pd=60 as=0 ps=0
M1019 a_n47_n29# Ck_mcc vdd w_n5_n1# CMOSP w=20 l=2
+  ad=280 pd=68 as=0 ps=0
M1020 vdd a2_l a_175_175# w_162_204# CMOSP w=20 l=2
+  ad=0 pd=0 as=0 ps=0
M1021 a_288_180# b3_l vdd w_275_209# CMOSP w=20 l=2
+  ad=200 pd=100 as=0 ps=0
M1022 a_n92_68# a0_l vdd w_n105_87# CMOSP w=20 l=2
+  ad=100 pd=50 as=0 ps=0
M1023 a_288_180# b3_l a_281_180# Gnd CMOSN w=20 l=2
+  ad=100 pd=50 as=200 ps=100
M1024 b0_l a0_l p0 w_n75_94# CMOSP w=20 l=2
+  ad=100 pd=50 as=200 ps=100
M1025 a_n92_68# a0_l gnd Gnd CMOSN w=10 l=2
+  ad=100 pd=60 as=0 ps=0
M1026 p0 a_n92_68# b0_l Gnd CMOSN w=10 l=2
+  ad=100 pd=60 as=50 ps=30
M1027 g3 a_288_180# vdd w_275_209# CMOSP w=20 l=2
+  ad=100 pd=50 as=0 ps=0
M1028 p4 b4_l a4_l w_396_102# CMOSP w=20 l=2
+  ad=200 pd=100 as=100 ps=50
M1029 gnd Ck_mcc a_208_n93# Gnd CMOSN w=20 l=2
+  ad=0 pd=0 as=560 ps=136
M1030 p0 b0_l a_n92_68# Gnd CMOSN w=10 l=2
+  ad=0 pd=0 as=0 ps=0
M1031 a_56_n29# g1 a_107_n93# Gnd CMOSN w=20 l=2
+  ad=840 pd=204 as=560 ps=136
M1032 a_367_n29# g4 a_412_n93# Gnd CMOSN w=20 l=2
+  ad=560 pd=136 as=560 ps=136
M1033 a_175_175# b2_l a_168_175# Gnd CMOSN w=20 l=2
+  ad=100 pd=50 as=200 ps=100
M1034 p3 a_267_76# b3_l Gnd CMOSN w=10 l=2
+  ad=100 pd=60 as=50 ps=30
M1035 a_263_n29# Ck_mcc vdd w_304_n1# CMOSP w=20 l=2
+  ad=280 pd=68 as=0 ps=0
M1036 C3 a_161_n29# vdd w_270_n163# CMOSP w=20 l=2
+  ad=180 pd=58 as=0 ps=0
M1037 vdd a3_l a_288_180# w_275_209# CMOSP w=20 l=2
+  ad=0 pd=0 as=0 ps=0
M1038 a_32_69# a1_l vdd w_19_88# CMOSP w=20 l=2
+  ad=100 pd=50 as=0 ps=0
M1039 a_n47_n29# p1 a_56_n29# Gnd CMOSN w=20 l=2
+  ad=840 pd=204 as=0 ps=0
M1040 a_281_180# a3_l gnd Gnd CMOSN w=20 l=2
+  ad=0 pd=0 as=0 ps=0
M1041 b1_l a1_l p1 w_49_95# CMOSP w=20 l=2
+  ad=100 pd=50 as=0 ps=0
M1042 a_32_69# a1_l gnd Gnd CMOSN w=10 l=2
+  ad=100 pd=60 as=0 ps=0
M1043 b4_l a4_l p4 w_396_102# CMOSP w=20 l=2
+  ad=100 pd=50 as=0 ps=0
M1044 a_263_n29# p4 a_367_n29# Gnd CMOSN w=20 l=2
+  ad=840 pd=204 as=0 ps=0
M1045 g0 a_n68_172# vdd w_n81_201# CMOSP w=20 l=2
+  ad=100 pd=50 as=0 ps=0
M1046 p2 b2_l a2_l w_166_97# CMOSP w=20 l=2
+  ad=200 pd=100 as=100 ps=50
M1047 b3_l a3_l p3 w_284_102# CMOSP w=20 l=2
+  ad=100 pd=50 as=200 ps=100
M1048 a_56_n29# p2 a_161_n29# Gnd CMOSN w=20 l=2
+  ad=0 pd=0 as=840 ps=204
M1049 gnd Ck_mcc a_n102_n93# Gnd CMOSN w=20 l=2
+  ad=0 pd=0 as=560 ps=136
M1050 gnd Ck_mcc a_3_n93# Gnd CMOSN w=20 l=2
+  ad=0 pd=0 as=560 ps=136
M1051 C2 a_56_n29# vdd w_170_n163# CMOSP w=20 l=2
+  ad=180 pd=58 as=0 ps=0
M1052 a_168_175# a2_l gnd Gnd CMOSN w=20 l=2
+  ad=0 pd=0 as=0 ps=0
M1053 C1 a_n47_n29# gnd Gnd CMOSN w=10 l=2
+  ad=90 pd=38 as=0 ps=0
M1054 a_263_n29# g3 a_312_n93# Gnd CMOSN w=20 l=2
+  ad=0 pd=0 as=560 ps=136
M1055 p3 b3_l a3_l w_284_102# CMOSP w=20 l=2
+  ad=0 pd=0 as=100 ps=50
M1056 a_379_76# a4_l vdd w_366_95# CMOSP w=20 l=2
+  ad=100 pd=50 as=0 ps=0
M1057 C4 a_263_n29# gnd Gnd CMOSN w=10 l=2
+  ad=90 pd=38 as=0 ps=0
M1058 a_267_76# a3_l vdd w_254_95# CMOSP w=20 l=2
+  ad=100 pd=50 as=0 ps=0
M1059 a_58_173# a_52_196# vdd w_45_202# CMOSP w=20 l=2
+  ad=0 pd=0 as=0 ps=0
M1060 p0 b0_l a0_l w_n75_94# CMOSP w=20 l=2
+  ad=0 pd=0 as=100 ps=50
M1061 p2 b2_l a_149_71# Gnd CMOSN w=10 l=2
+  ad=100 pd=60 as=100 ps=60
M1062 a_58_173# a_52_196# a_51_173# Gnd CMOSN w=20 l=2
+  ad=100 pd=50 as=0 ps=0
M1063 g1 a_58_173# gnd Gnd CMOSN w=10 l=2
+  ad=50 pd=30 as=0 ps=0
M1064 a_161_n29# p3 a_263_n29# Gnd CMOSN w=20 l=2
+  ad=0 pd=0 as=0 ps=0
M1065 p3 b3_l a_267_76# Gnd CMOSN w=10 l=2
+  ad=0 pd=0 as=0 ps=0
M1066 a_n86_n52# p0 a_n47_n29# Gnd CMOSN w=20 l=2
+  ad=560 pd=136 as=0 ps=0
M1067 a_161_n29# Ck_mcc vdd w_200_n1# CMOSP w=20 l=2
+  ad=280 pd=68 as=0 ps=0
M1068 vdd b0_l a_n68_172# w_n81_201# CMOSP w=20 l=2
+  ad=0 pd=0 as=200 ps=100
M1069 p4 b4_l a_379_76# Gnd CMOSN w=10 l=2
+  ad=0 pd=0 as=100 ps=60
M1070 gnd Ck_mcc a_107_n93# Gnd CMOSN w=20 l=2
+  ad=0 pd=0 as=0 ps=0
M1071 gnd Ck_mcc a_412_n93# Gnd CMOSN w=20 l=2
+  ad=0 pd=0 as=0 ps=0
M1072 a_n75_172# b0_l gnd Gnd CMOSN w=20 l=2
+  ad=200 pd=100 as=0 ps=0
M1073 b2_l a2_l p2 w_166_97# CMOSP w=20 l=2
+  ad=100 pd=50 as=0 ps=0
M1074 a_161_n29# g2 a_208_n93# Gnd CMOSN w=20 l=2
+  ad=0 pd=0 as=0 ps=0
M1075 C1 a_n47_n29# vdd w_58_n166# CMOSP w=20 l=2
+  ad=180 pd=58 as=0 ps=0
M1076 C0 a_n86_n52# gnd Gnd CMOSN w=10 l=2
+  ad=90 pd=38 as=0 ps=0
M1077 a_405_180# b4_l vdd w_392_209# CMOSP w=20 l=2
+  ad=0 pd=0 as=0 ps=0
M1078 a_149_71# a2_l gnd Gnd CMOSN w=10 l=2
+  ad=0 pd=0 as=0 ps=0
M1079 C5 a_367_n29# gnd Gnd CMOSN w=10 l=2
+  ad=140 pd=48 as=0 ps=0
M1080 a_405_180# b4_l a_398_180# Gnd CMOSN w=20 l=2
+  ad=100 pd=50 as=0 ps=0
M1081 a_n86_n52# Ck_mcc vdd w_n109_n1# CMOSP w=20 l=2
+  ad=280 pd=68 as=0 ps=0
M1082 C4 a_263_n29# vdd w_375_n165# CMOSP w=20 l=2
+  ad=180 pd=58 as=0 ps=0
M1083 a_n68_172# a0_l vdd w_n81_201# CMOSP w=20 l=2
+  ad=0 pd=0 as=0 ps=0
M1084 g4 a_405_180# gnd Gnd CMOSN w=10 l=2
+  ad=50 pd=30 as=0 ps=0
M1085 p1 b1_l a_32_69# Gnd CMOSN w=10 l=2
+  ad=0 pd=0 as=0 ps=0
M1086 g1 a_58_173# vdd w_45_202# CMOSP w=20 l=2
+  ad=100 pd=50 as=0 ps=0
M1087 a_379_76# a4_l gnd Gnd CMOSN w=10 l=2
+  ad=0 pd=0 as=0 ps=0
M1088 a_n86_n52# c0_l a_n102_n93# Gnd CMOSN w=20 l=2
+  ad=0 pd=0 as=0 ps=0
M1089 a_n68_172# a0_l a_n75_172# Gnd CMOSN w=20 l=2
+  ad=100 pd=50 as=0 ps=0
M1090 g3 a_288_180# gnd Gnd CMOSN w=10 l=2
+  ad=50 pd=30 as=0 ps=0
M1091 a_n47_n29# g0 a_3_n93# Gnd CMOSN w=20 l=2
+  ad=0 pd=0 as=0 ps=0
M1092 p2 a_149_71# b2_l Gnd CMOSN w=10 l=2
+  ad=0 pd=0 as=50 ps=30
M1093 a_56_n29# Ck_mcc vdd w_99_n1# CMOSP w=20 l=2
+  ad=280 pd=68 as=0 ps=0
M1094 gnd Ck_mcc a_312_n93# Gnd CMOSN w=20 l=2
+  ad=0 pd=0 as=0 ps=0
C0 a_n47_n29# vdd 0.16fF
C1 a_n47_n29# w_58_n166# 0.08fF
C2 a_161_n29# w_270_n163# 0.08fF
C3 b0_l a_n68_172# 0.12fF
C4 c0_l Ck_mcc 0.16fF
C5 a_58_173# g1 0.06fF
C6 a_367_n29# g4 0.42fF
C7 vdd p2 0.10fF
C8 gnd a_3_n93# 0.09fF
C9 w_n81_201# b0_l 0.07fF
C10 gnd p1 0.16fF
C11 b2_l g2 0.37fF
C12 b3_l p3 0.63fF
C13 a_267_76# vdd 0.21fF
C14 a_149_71# b2_l 0.11fF
C15 vdd w_170_n163# 0.14fF
C16 w_304_n1# Ck_mcc 0.16fF
C17 a_398_180# b4_l 0.05fF
C18 b1_l a_32_69# 0.11fF
C19 a_n86_n52# c0_l 0.07fF
C20 a_288_180# g3 0.06fF
C21 a_3_n93# Ck_mcc 0.07fF
C22 w_99_n1# Ck_mcc 0.15fF
C23 a_175_175# a2_l 0.12fF
C24 a_405_180# g4 0.06fF
C25 a_405_180# w_392_209# 0.31fF
C26 w_n75_94# a0_l 0.32fF
C27 a3_l w_275_209# 0.07fF
C28 gnd g2 0.42fF
C29 a_149_71# gnd 0.24fF
C30 a2_l vdd 0.12fF
C31 w_375_n165# C4 0.06fF
C32 a_32_69# p1 0.37fF
C33 a4_l w_392_209# 0.07fF
C34 w_475_n7# C5 0.07fF
C35 gnd Ck_mcc 2.06fF
C36 g0 a_3_n93# 0.15fF
C37 a3_l w_254_95# 0.16fF
C38 w_404_n1# a_367_n29# 0.07fF
C39 a_161_n29# w_200_n1# 0.08fF
C40 g2 Ck_mcc 0.19fF
C41 a_56_n29# w_99_n1# 0.08fF
C42 a_56_n29# p1 0.31fF
C43 gnd a_32_69# 0.28fF
C44 a_367_n29# C5 0.06fF
C45 a_n86_n52# gnd 0.20fF
C46 vdd w_475_n7# 0.12fF
C47 g0 gnd 0.39fF
C48 a_263_n29# p4 0.19fF
C49 gnd C3 0.12fF
C50 w_275_209# b3_l 0.07fF
C51 a3_l vdd 0.12fF
C52 a_56_n29# gnd 0.20fF
C53 vdd a_367_n29# 0.06fF
C54 vdd a_n68_172# 0.49fF
C55 vdd w_270_n163# 0.14fF
C56 a_n86_n52# Ck_mcc 0.21fF
C57 a2_l p2 0.46fF
C58 g0 Ck_mcc 0.19fF
C59 vdd w_284_102# 0.01fF
C60 a_288_180# a_281_180# 0.21fF
C61 C2 gnd 0.12fF
C62 a_n75_172# b0_l 0.09fF
C63 vdd w_n81_201# 0.26fF
C64 a_56_n29# Ck_mcc 0.55fF
C65 a_n92_68# gnd 0.20fF
C66 a_379_76# w_366_95# 0.05fF
C67 a0_l a_n68_172# 0.05fF
C68 a_n92_68# w_n105_87# 0.05fF
C69 a_51_173# gnd 0.54fF
C70 a_379_76# vdd 0.21fF
C71 a_58_173# gnd 0.32fF
C72 a3_l a_288_180# 0.12fF
C73 a0_l w_n81_201# 0.07fF
C74 a4_l w_396_102# 0.32fF
C75 b1_l w_49_95# 0.16fF
C76 a_405_180# vdd 0.49fF
C77 a4_l w_366_95# 0.16fF
C78 vdd g1 0.93fF
C79 w_396_102# p4 0.13fF
C80 b2_l a_168_175# 0.05fF
C81 gnd p3 0.16fF
C82 a4_l vdd 0.07fF
C83 b2_l w_166_97# 0.16fF
C84 a_379_76# b4_l 0.11fF
C85 a_267_76# a3_l 0.30fF
C86 w_n5_n1# Ck_mcc 0.16fF
C87 vdd p4 0.11fF
C88 a_405_180# b4_l 0.05fF
C89 a_263_n29# C4 0.07fF
C90 w_49_95# p1 0.13fF
C91 a_161_n29# gnd 0.20fF
C92 gnd b0_l 0.24fF
C93 a_263_n29# w_304_n1# 0.08fF
C94 a_149_71# w_136_90# 0.05fF
C95 a4_l b4_l 0.04fF
C96 a_312_n93# gnd 0.09fF
C97 gnd g4 0.10fF
C98 vdd w_200_n1# 0.12fF
C99 g3 b3_l 0.47fF
C100 a_56_n29# C2 0.07fF
C101 p4 b4_l 0.63fF
C102 a_161_n29# g2 0.44fF
C103 a_168_175# gnd 0.56fF
C104 a_288_180# b3_l 0.05fF
C105 w_45_202# g1 0.05fF
C106 g0 w_n5_n1# 0.18fF
C107 a4_l g3 0.03fF
C108 a_161_n29# Ck_mcc 0.61fF
C109 a_398_180# a_405_180# 0.21fF
C110 a_312_n93# Ck_mcc 0.07fF
C111 g4 Ck_mcc 0.22fF
C112 a_107_n93# g1 0.15fF
C113 a_175_175# w_162_204# 0.31fF
C114 a_267_76# b3_l 0.11fF
C115 a_263_n29# gnd 0.20fF
C116 a4_l a_398_180# 0.05fF
C117 b1_l a1_l 0.04fF
C118 a_52_196# a_51_173# 0.05fF
C119 a3_l a_281_180# 0.05fF
C120 w_162_204# vdd 0.24fF
C121 a_52_196# a_58_173# 0.05fF
C122 g0 b0_l 0.58fF
C123 a_161_n29# C3 0.07fF
C124 a_175_175# b2_l 0.05fF
C125 C1 gnd 0.12fF
C126 gnd C0 0.12fF
C127 a_263_n29# Ck_mcc 0.53fF
C128 a_58_173# a_51_173# 0.21fF
C129 vdd C4 0.20fF
C130 a1_l p1 0.46fF
C131 p0 gnd 0.17fF
C132 vdd w_304_n1# 0.12fF
C133 a_367_n29# w_475_n7# 0.08fF
C134 a0_l a_n75_172# 0.05fF
C135 w_99_n1# vdd 0.12fF
C136 vdd p1 0.11fF
C137 a3_l w_284_102# 0.32fF
C138 w_404_n1# Ck_mcc 0.17fF
C139 a1_l gnd 0.04fF
C140 a_175_175# gnd 0.32fF
C141 a_n92_68# b0_l 0.11fF
C142 a_281_180# b3_l 0.05fF
C143 w_375_n165# a_263_n29# 0.08fF
C144 w_n81_201# a_n68_172# 0.35fF
C145 a_175_175# g2 0.06fF
C146 vdd gnd 0.27fF
C147 vdd w_n105_87# 0.05fF
C148 g3 w_304_n1# 0.18fF
C149 a_n86_n52# C0 0.07fF
C150 a_161_n29# p3 0.19fF
C151 a3_l b3_l 0.04fF
C152 a_n102_n93# c0_l 0.15fF
C153 vdd g2 0.81fF
C154 a_n86_n52# p0 0.19fF
C155 a_n86_n52# w_n43_n164# 0.08fF
C156 a_149_71# vdd 0.21fF
C157 a0_l gnd 0.20fF
C158 a_n47_n29# p1 0.19fF
C159 a0_l w_n105_87# 0.16fF
C160 b2_l p2 0.63fF
C161 vdd Ck_mcc 0.83fF
C162 a1_l a_32_69# 0.30fF
C163 b3_l w_284_102# 0.16fF
C164 w_19_88# a_32_69# 0.05fF
C165 g3 gnd 0.32fF
C166 a1_l g0 0.03fF
C167 a_367_n29# p4 0.33fF
C168 a_288_180# gnd 0.32fF
C169 vdd a_32_69# 0.21fF
C170 a_n47_n29# gnd 0.20fF
C171 a_263_n29# p3 0.29fF
C172 a2_l w_162_204# 0.07fF
C173 g4 w_392_209# 0.05fF
C174 a_n86_n52# vdd 0.20fF
C175 w_n109_n1# Ck_mcc 0.15fF
C176 vdd g0 0.91fF
C177 a_398_180# gnd 0.53fF
C178 a_107_n93# gnd 0.09fF
C179 vdd C3 0.20fF
C180 a_n92_68# p0 0.35fF
C181 a4_l a_379_76# 0.30fF
C182 gnd p2 0.33fF
C183 w_375_n165# vdd 0.14fF
C184 g3 Ck_mcc 0.18fF
C185 a_56_n29# vdd 0.16fF
C186 a_267_76# gnd 0.20fF
C187 a4_l a_405_180# 0.12fF
C188 a_379_76# p4 0.35fF
C189 b2_l a2_l 0.04fF
C190 a_n47_n29# Ck_mcc 0.75fF
C191 a_n102_n93# gnd 0.10fF
C192 a_149_71# p2 0.33fF
C193 a_n86_n52# w_n109_n1# 0.08fF
C194 a_51_173# a1_l 0.05fF
C195 a_107_n93# Ck_mcc 0.07fF
C196 C2 vdd 0.20fF
C197 a4_l p4 0.46fF
C198 a_58_173# a1_l 0.12fF
C199 a_n92_68# vdd 0.21fF
C200 a_n102_n93# Ck_mcc 0.07fF
C201 a_n47_n29# g0 0.50fF
C202 w_404_n1# g4 0.18fF
C203 p0 b0_l 0.63fF
C204 a_58_173# vdd 0.49fF
C205 vdd w_n5_n1# 0.12fF
C206 a2_l gnd 0.04fF
C207 a_n75_172# a_n68_172# 0.21fF
C208 a_n92_68# a0_l 0.30fF
C209 vdd p3 0.11fF
C210 a_149_71# a2_l 0.30fF
C211 vdd w_136_90# 0.05fF
C212 a_281_180# gnd 0.53fF
C213 a_56_n29# p2 0.19fF
C214 a_52_196# w_45_202# 0.07fF
C215 a_175_175# a_168_175# 0.21fF
C216 a_161_n29# vdd 0.16fF
C217 vdd b0_l 0.08fF
C218 a_56_n29# w_170_n163# 0.08fF
C219 a1_l w_49_95# 0.32fF
C220 gnd a_208_n93# 0.09fF
C221 vdd g4 0.73fF
C222 a_58_173# w_45_202# 0.31fF
C223 a3_l gnd 0.04fF
C224 a_412_n93# gnd 0.09fF
C225 a_n47_n29# w_n5_n1# 0.08fF
C226 b1_l g1 0.47fF
C227 vdd w_392_209# 0.24fF
C228 g2 a_208_n93# 0.15fF
C229 w_166_97# vdd 0.01fF
C230 C2 w_170_n163# 0.06fF
C231 a0_l b0_l 0.04fF
C232 a_367_n29# gnd 0.09fF
C233 gnd a_n68_172# 0.32fF
C234 C0 w_n43_n164# 0.06fF
C235 g4 b4_l 0.26fF
C236 a_208_n93# Ck_mcc 0.07fF
C237 w_392_209# b4_l 0.07fF
C238 a_412_n93# Ck_mcc 0.07fF
C239 w_99_n1# g1 0.20fF
C240 a_263_n29# vdd 0.16fF
C241 a_312_n93# g3 0.15fF
C242 a_267_76# p3 0.37fF
C243 a_367_n29# Ck_mcc 0.46fF
C244 a_379_76# gnd 0.20fF
C245 a_405_180# gnd 0.32fF
C246 a_161_n29# p2 0.34fF
C247 gnd g1 0.45fF
C248 w_275_209# vdd 0.24fF
C249 vdd C0 0.20fF
C250 C1 vdd 0.20fF
C251 C1 w_58_n166# 0.06fF
C252 w_404_n1# vdd 0.12fF
C253 a4_l gnd 0.04fF
C254 vdd w_n43_n164# 0.14fF
C255 p0 vdd 0.11fF
C256 g3 a_263_n29# 0.51fF
C257 g0 a_n68_172# 0.06fF
C258 w_n75_94# b0_l 0.16fF
C259 w_254_95# vdd 0.05fF
C260 a1_l w_19_88# 0.16fF
C261 w_166_97# p2 0.13fF
C262 C3 w_270_n163# 0.06fF
C263 vdd C5 0.06fF
C264 g1 Ck_mcc 0.18fF
C265 g0 w_n81_201# 0.05fF
C266 a2_l w_136_90# 0.16fF
C267 vdd a1_l 0.07fF
C268 a_175_175# vdd 0.49fF
C269 a0_l p0 0.46fF
C270 vdd w_19_88# 0.05fF
C271 g3 w_275_209# 0.05fF
C272 b2_l w_162_204# 0.07fF
C273 vdd w_366_95# 0.05fF
C274 a_288_180# w_275_209# 0.31fF
C275 w_200_n1# g2 0.18fF
C276 C1 a_n47_n29# 0.07fF
C277 w_58_n166# vdd 0.14fF
C278 w_200_n1# Ck_mcc 0.16fF
C279 w_396_102# b4_l 0.16fF
C280 a_n47_n29# p0 0.24fF
C281 a_168_175# a2_l 0.05fF
C282 b1_l p1 0.63fF
C283 a2_l w_166_97# 0.32fF
C284 a_56_n29# g1 0.53fF
C285 a3_l p3 0.46fF
C286 a0_l vdd 0.23fF
C287 w_45_202# a1_l 0.07fF
C288 vdd w_n109_n1# 0.12fF
C289 a_n75_172# gnd 0.53fF
C290 a_267_76# w_254_95# 0.05fF
C291 w_284_102# p3 0.13fF
C292 g3 vdd 0.87fF
C293 w_162_204# g2 0.05fF
C294 gnd C4 0.12fF
C295 w_n75_94# p0 0.13fF
C296 w_45_202# vdd 0.24fF
C297 a_288_180# vdd 0.49fF
C298 a_412_n93# g4 0.15fF
C299 C4 Gnd 0.11fF
C300 C3 Gnd 0.11fF
C301 C2 Gnd 0.11fF
C302 C1 Gnd 0.11fF
C303 C0 Gnd 0.11fF
C304 a_412_n93# Gnd 0.18fF
C305 a_312_n93# Gnd 0.18fF
C306 a_208_n93# Gnd 0.18fF
C307 a_107_n93# Gnd 0.18fF
C308 a_3_n93# Gnd 0.18fF
C309 a_n102_n93# Gnd 0.18fF
C310 c0_l Gnd 0.45fF
C311 C5 Gnd 0.17fF
C312 a_367_n29# Gnd 0.86fF
C313 a_263_n29# Gnd 2.36fF
C314 a_161_n29# Gnd 2.32fF
C315 a_56_n29# Gnd 2.35fF
C316 a_n47_n29# Gnd 2.35fF
C317 a_n86_n52# Gnd 2.02fF
C318 Ck_mcc Gnd 6.44fF
C319 p4 Gnd 0.78fF
C320 a_379_76# Gnd 0.36fF
C321 a4_l Gnd 0.27fF
C322 p3 Gnd 0.78fF
C323 a_267_76# Gnd 0.36fF
C324 a3_l Gnd 0.25fF
C325 p2 Gnd 0.72fF
C326 a_149_71# Gnd 0.19fF
C327 a2_l Gnd 0.36fF
C328 p1 Gnd 0.70fF
C329 a_32_69# Gnd 0.36fF
C330 a1_l Gnd 0.45fF
C331 p0 Gnd 0.02fF
C332 a_n92_68# Gnd 0.19fF
C333 b2_l Gnd 0.98fF
C334 b1_l Gnd 0.89fF
C335 b4_l Gnd 1.02fF
C336 b3_l Gnd 1.02fF
C337 a_398_180# Gnd 0.42fF
C338 a_281_180# Gnd 0.42fF
C339 a_168_175# Gnd 0.42fF
C340 a_51_173# Gnd 0.42fF
C341 gnd Gnd 16.04fF
C342 a_n75_172# Gnd 0.42fF
C343 g4 Gnd 1.88fF
C344 g3 Gnd 1.70fF
C345 g2 Gnd 1.64fF
C346 g1 Gnd 1.48fF
C347 g0 Gnd 0.04fF
C348 vdd Gnd 9.66fF
C349 a_175_175# Gnd 0.43fF
C350 a_58_173# Gnd 0.43fF
C351 a_52_196# Gnd 0.14fF
C352 a_n68_172# Gnd 0.13fF
C353 b0_l Gnd 1.61fF
C354 a0_l Gnd 2.10fF
C355 a_405_180# Gnd 0.43fF
C356 a_288_180# Gnd 0.43fF
C357 w_375_n165# Gnd 1.49fF
C358 w_270_n163# Gnd 0.80fF
C359 w_170_n163# Gnd 1.49fF
C360 w_58_n166# Gnd 1.49fF
C361 w_n43_n164# Gnd 1.37fF
C362 w_475_n7# Gnd 1.62fF
C363 w_404_n1# Gnd 1.62fF
C364 w_304_n1# Gnd 1.62fF
C365 w_200_n1# Gnd 1.62fF
C366 w_99_n1# Gnd 1.62fF
C367 w_n5_n1# Gnd 1.62fF
C368 w_n109_n1# Gnd 1.58fF
C369 w_396_102# Gnd 2.14fF
C370 w_366_95# Gnd 0.84fF
C371 w_284_102# Gnd 2.14fF
C372 w_254_95# Gnd 0.84fF
C373 w_166_97# Gnd 2.14fF
C374 w_136_90# Gnd 0.84fF
C375 w_49_95# Gnd 2.14fF
C376 w_19_88# Gnd 0.84fF
C377 w_n75_94# Gnd 2.14fF
C378 w_n105_87# Gnd 0.84fF
C379 w_392_209# Gnd 2.18fF
C380 w_275_209# Gnd 2.18fF
C381 w_162_204# Gnd 0.92fF
C382 w_45_202# Gnd 2.18fF
C383 w_n81_201# Gnd 2.43fF

.tran 0.1n 100n

.control

set hcopypscolor = 1 *White background for saving plots
set color0=white
set color1=black

run
set curplottitle = "manchester_carry_chain"

plot V(C1)+8 V(C2)+6 V(C3)+4 V(C4)+2 V(C5) V(Ck_mcc)+10

meas tran t_eval TRIG V(ck_mcc) VAL=0.5*{SUPPLY} RISE=1 TARG V(C5) VAL=0.9*{SUPPLY} RISE=1

echo "t_eval = " $&t_eval

.endc
.end
