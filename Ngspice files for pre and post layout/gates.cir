* projext
.include TSMC_180nm.txt
.param SUPPLY=1.8
.param LAMBDA=0.09u
.global gnd vdd

.param width_N=10*LAMBDA
.param width_P=2*width_N

Vdd vdd 0 {SUPPLY}

Va a 0 PULSE(0 {SUPPLY} 8n 5p 5p 15n 30n)
Vb b 0 PULSE(0 {SUPPLY} 8n 5p 5p 20n 40n)

.subckt inv out in vdd gnd

M_Pinv out in vdd vdd CMOSP W={width_P}   L={2*LAMBDA}
+ AS={5*width_P*LAMBDA} PS={10*LAMBDA+2*width_P} AD={5*width_P*LAMBDA} PD={10*LAMBDA+2*width_P}
M_Ninv out in 0 0 CMOSN W={width_N}   L={2*LAMBDA}
+ AS={5*width_N*LAMBDA} PS={10*LAMBDA+2*width_N} AD={5*width_N*LAMBDA} PD={10*LAMBDA+2*width_N}
.ends inv

.subckt nand2 out a b vdd gnd
Mnandp1 out a vdd vdd CMOSP W={width_P}   L={2*LAMBDA}
+ AS={5*width_P*LAMBDA} PS={10*LAMBDA+2*width_P} AD={5*width_P*LAMBDA} PD={10*LAMBDA+2*width_P}
Mnandp2 out b vdd vdd CMOSP W={width_P}   L={2*LAMBDA}
+ AS={5*width_P*LAMBDA} PS={10*LAMBDA+2*width_P} AD={5*width_P*LAMBDA} PD={10*LAMBDA+2*width_P}
Mnandn1 out a nbot gnd CMOSN W={2*width_N}   L={2*LAMBDA}
+ AS={5*width_N*LAMBDA} PS={10*LAMBDA+2*width_N} AD={5*width_N*LAMBDA} PD={10*LAMBDA+2*width_N}
Mnandn2 nbot b gnd gnd CMOSN W={2*width_N}   L={2*LAMBDA}
+ AS={5*width_N*LAMBDA} PS={10*LAMBDA+2*width_N} AD={5*width_N*LAMBDA} PD={10*LAMBDA+2*width_N}
.ends nand2

.subckt and2 out a b vdd gnd
Xn nand_out a b vdd gnd nand2
Xin out nand_out vdd gnd inv

.ends and2

.subckt xor2 out a b vdd gnd
Xinva a_bar a vdd gnd inv

M1 out b a vdd CMOSP W={width_P}   L={2*LAMBDA}
+ AS={5*width_P*LAMBDA} PS={10*LAMBDA+2*width_P} AD={5*width_P*LAMBDA} PD={10*LAMBDA+2*width_P}
M2 out b a_bar gnd CMOSN W={width_N}   L={2*LAMBDA}
+ AS={5*width_N*LAMBDA} PS={10*LAMBDA+2*width_N} AD={5*width_N*LAMBDA} PD={10*LAMBDA+2*width_N}

M3 out a b vdd CMOSP W={width_P}   L={2*LAMBDA}
+ AS={5*width_P*LAMBDA} PS={10*LAMBDA+2*width_P} AD={5*width_P*LAMBDA} PD={10*LAMBDA+2*width_P}
M4 b a_bar out gnd CMOSN W={width_N}   L={2*LAMBDA}
+ AS={5*width_N*LAMBDA} PS={10*LAMBDA+2*width_N} AD={5*width_N*LAMBDA} PD={10*LAMBDA+2*width_N}
.ends xor2

* Xxor1 y a b vdd gnd xor2

* .tran 0.1n 200n

* .control

* set hcopypscolor = 1
* set color0=white
* set color1=black

* run

* meas tran t_delay TRIG V(a) VAL=0.5*{SUPPLY} fall=3 TARG V(y) VAL=0.5*{SUPPLY} fall=4
* plot V(a)+4 V(b)+2 V(y)

* .endc
* .end
