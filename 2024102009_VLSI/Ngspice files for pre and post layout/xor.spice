* SPICE3 file created from xor.ext - technology: scmos

.include TSMC_180nm.txt
.param SUPPLY=1.8

.global gnd vdd

Vdd vdd 0 {SUPPLY}

Va a 0 PULSE(0 {SUPPLY} 8n 5p 5p 15n 30n)
Vb b 0 PULSE(0 {SUPPLY} 8n 5p 5p 20n 40n)

.option scale=0.09u

M1000 a_bar a vdd w_93_n6# CMOSP w=20 l=2
+  ad=100 pd=50 as=100 ps=50
M1001 a_bar a GND Gnd CMOSN w=10 l=2
+  ad=100 pd=60 as=50 ps=30
M1002 b a out w_123_1# CMOSP w=20 l=2
+  ad=100 pd=50 as=200 ps=100
M1003 out b a w_123_1# CMOSP w=20 l=2
+  ad=0 pd=0 as=100 ps=50
M1004 out a_bar b Gnd CMOSN w=10 l=2
+  ad=100 pd=60 as=50 ps=30
M1005 out b a_bar Gnd CMOSN w=10 l=2
+  ad=0 pd=0 as=0 ps=0
C0 vdd w_93_n6# 0.05fF
C1 w_123_1# a 0.32fF
C2 b a_bar 0.11fF
C3 vdd a 0.07fF
C4 GND a 0.04fF
C5 out a_bar 0.20fF
C6 a_bar w_93_n6# 0.05fF
C7 out b 0.61fF
C8 a_bar a 0.30fF
C9 b a 0.04fF
C10 w_123_1# b 0.16fF
C11 vdd a_bar 0.21fF
C12 out a 0.46fF
C13 a w_93_n6# 0.16fF
C14 GND a_bar 0.20fF
C15 out w_123_1# 0.13fF
C16 GND Gnd 0.03fF
C17 out Gnd 0.15fF
C18 a_bar Gnd 0.36fF
C19 vdd Gnd 0.07fF
C20 a Gnd 0.30fF
C21 b Gnd 0.86fF
C22 w_123_1# Gnd 1.96fF
C23 w_93_n6# Gnd 0.84fF

.tran 0.1n 200n

.control

set hcopypscolor = 1
set color0=white
set color1=black

run

meas tran t_delay TRIG V(a) VAL=0.5*{SUPPLY} fall=3 TARG V(out) VAL=0.5*{SUPPLY} fall=4
plot V(a)+4 V(b)+2 V(out)

.endc
.end
