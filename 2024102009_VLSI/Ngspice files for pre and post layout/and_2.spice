* SPICE3 file created from and_2.ext - technology: scmos

.include TSMC_180nm.txt
.param SUPPLY=1.8

.global gnd vdd

Vdd vdd 0 {SUPPLY}

Va a 0 PULSE(0 {SUPPLY} 8n 5p 5p 15n 30n)
Vb b 0 PULSE(0 {SUPPLY} 8n 5p 5p 20n 40n)

.option scale=0.09u

M1000 a_n90_n1# b vdd w_n103_28# CMOSP w=20 l=2
+  ad=200 pd=100 as=300 ps=150
M1001 a_n90_n1# b a_n97_n1# Gnd CMOSN w=20 l=2
+  ad=100 pd=50 as=200 ps=100
M1002 vdd a a_n90_n1# w_n103_28# CMOSP w=20 l=2
+  ad=0 pd=0 as=0 ps=0
M1003 out a_n90_n1# vdd w_n103_28# CMOSP w=20 l=2
+  ad=100 pd=50 as=0 ps=0
M1004 out a_n90_n1# gnd Gnd CMOSN w=10 l=2
+  ad=50 pd=30 as=150 ps=80
M1005 a_n97_n1# a gnd Gnd CMOSN w=20 l=2
+  ad=0 pd=0 as=0 ps=0
C0 out vdd 0.25fF
C1 gnd out 0.10fF
C2 w_n103_28# vdd 0.24fF
C3 w_n103_28# out 0.05fF
C4 a_n97_n1# gnd 0.53fF
C5 a_n90_n1# vdd 0.49fF
C6 a_n90_n1# out 0.06fF
C7 w_n103_28# b 0.07fF
C8 gnd a_n90_n1# 0.32fF
C9 a_n97_n1# b 0.05fF
C10 b a_n90_n1# 0.05fF
C11 w_n103_28# a_n90_n1# 0.31fF
C12 w_n103_28# a 0.07fF
C13 a_n97_n1# a_n90_n1# 0.21fF
C14 a_n97_n1# a 0.05fF
C15 a a_n90_n1# 0.12fF
C16 gnd Gnd 0.31fF
C17 a_n97_n1# Gnd 0.42fF
C18 out Gnd 0.06fF
C19 vdd Gnd 0.06fF
C20 a_n90_n1# Gnd 0.43fF
C21 a Gnd 0.14fF
C22 b Gnd 0.13fF
C23 w_n103_28# Gnd 2.18fF

.tran 0.1n 200n

.control

set hcopypscolor = 1 *White background for saving plots
set color0=white
set color1=black

run

plot V(a)+4 V(b)+2 V(out)

.endc
.end
