* projext
.include TSMC_180nm.txt
.param SUPPLY=1.8
.param LAMBDA=0.09u
.global gnd vdd

.param width_N=10*LAMBDA
.param width_P=2*width_N

VCK ck 0 PULSE(0 {SUPPLY} 5n 5p 5p 20n 40n)
Vdd vdd 0 {SUPPLY}

Vin vin 0 PULSE(0 {SUPPLY} 8n 5p 5p 15n 30n)

.subckt inv out in vdd gnd

M_Pinv out in vdd vdd CMOSP W={width_P}   L={2*LAMBDA}
+ AS={5*width_P*LAMBDA} PS={10*LAMBDA+2*width_P} AD={5*width_P*LAMBDA} PD={10*LAMBDA+2*width_P}
M_Ninv out in 0 0 CMOSN W={width_N}   L={2*LAMBDA}
+ AS={5*width_N*LAMBDA} PS={10*LAMBDA+2*width_N} AD={5*width_N*LAMBDA} PD={10*LAMBDA+2*width_N}
.ends inv

*stage 1
M1 X vin gnd gnd CMOSN W={width_N}   L={2*LAMBDA}
+ AS={5*width_N*LAMBDA} PS={10*LAMBDA +2*width_N} AD={5*width_N*LAMBDA} PD={10*LAMBDA+2*width_N}
M2 X ck a1 vdd CMOSP W={width_P}   L={2*LAMBDA}
+ AS={5*width_P*LAMBDA} PS={10*LAMBDA +2*width_P} AD={5*width_P*LAMBDA} PD={10*LAMBDA+2*width_P}
M3 a1 vin vdd vdd CMOSP W={width_P}   L={2*LAMBDA}
+ AS={5*width_P*LAMBDA} PS={10*LAMBDA +2*width_P} AD={5*width_P*LAMBDA} PD={10*LAMBDA+2*width_P}

*stage 2

M4 a2 ck gnd gnd CMOSN W={width_N}   L={2*LAMBDA}
+ AS={5*width_N*LAMBDA} PS={10*LAMBDA +2*width_N} AD={5*width_N*LAMBDA} PD={10*LAMBDA+2*width_N}
M5 Y X a2 gnd CMOSN W={width_N}   L={2*LAMBDA}
+ AS={5*width_N*LAMBDA} PS={10*LAMBDA +2*width_N} AD={5*width_N*LAMBDA} PD={10*LAMBDA+2*width_N}
M6 Y ck vdd vdd CMOSP W={width_P}   L={2*LAMBDA}
+ AS={5*width_P*LAMBDA} PS={10*LAMBDA +2*width_P} AD={5*width_P*LAMBDA} PD={10*LAMBDA+2*width_P}

*stage 3
M7 a3 Y gnd gnd CMOSN W={width_N}   L={2*LAMBDA}
+ AS={5*width_N*LAMBDA} PS={10*LAMBDA +2*width_N} AD={5*width_N*LAMBDA} PD={10*LAMBDA+2*width_N}
M8 Q_bar ck a3 gnd CMOSN W={width_N}   L={2*LAMBDA}
+ AS={5*width_N*LAMBDA} PS={10*LAMBDA +2*width_N} AD={5*width_N*LAMBDA} PD={10*LAMBDA+2*width_N}
M9 Q_bar Y vdd vdd CMOSP W={width_P}   L={2*LAMBDA}
+ AS={5*width_P*LAMBDA} PS={10*LAMBDA +2*width_P} AD={5*width_P*LAMBDA} PD={10*LAMBDA+2*width_P}

Xinv Q Q_bar vdd gnd inv

.tran 0.1n 400n

.control

set hcopypscolor = 1 *White background for saving plots
set color0=white
set color1=black

run
meas tran t_setup TRIG V(vin) VAL=0.5*{SUPPLY} RISE=3 TARG V(X) VAL=0.5*{SUPPLY} FALL=3
meas tran tcq_rise TRIG V(ck) VAL=0.5*{SUPPLY} RISE=5 TARG V(Q) VAL=0.5*{SUPPLY} RISE=2
meas tran tcq_fall TRIG V(ck) VAL=0.5*{SUPPLY} RISE=6 TARG V(Q) VAL=0.5*{SUPPLY} FALL=3

let tcq = (tcq_rise + tcq_fall)/2
echo "tcq_avg" = " $&tcq"

plot V(ck)+2 V(vin)+4 V(Q) V(X)+6

.endc
.end
