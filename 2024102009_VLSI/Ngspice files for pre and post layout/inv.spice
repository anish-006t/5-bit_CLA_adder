* SPICE3 file created from inv.ext - technology: scmos

.include TSMC_180nm.txt
.param SUPPLY=1.8

.global gnd vdd

Vdd vdd 0 {SUPPLY}

Va in 0 PULSE(0 {SUPPLY} 8n 5p 5p 15n 30n)
.option scale=0.09u

M1000 out in VDD w_n7_n6# CMOSP w=20 l=2
+  ad=180 pd=58 as=180 ps=58
M1001 out in GND Gnd CMOSN w=10 l=2
+  ad=90 pd=38 as=90 ps=38
C0 out VDD 0.20fF
C1 VDD w_n7_n6# 0.14fF
C2 out GND 0.12fF
C3 out w_n7_n6# 0.06fF
C4 in GND 0.10fF
C5 in out 0.07fF
C6 in w_n7_n6# 0.08fF
C7 GND Gnd 0.15fF
C8 out Gnd 0.09fF
C9 VDD Gnd 0.04fF
C10 in Gnd 0.22fF
C11 w_n7_n6# Gnd 1.49fF

.tran 0.1n 100n

.control

set hcopypscolor = 1 *White background for saving plots
set color0=white
set color1=black

run

plot V(in)+2 V(out)

.endc
.end
